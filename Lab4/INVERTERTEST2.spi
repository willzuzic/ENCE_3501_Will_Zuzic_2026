*** SPICE deck for cell INVERTERTEST2{sch} from library Lab4
*** Created on Mon Mar 09, 2026 22:12:13
*** Last revised on Mon Mar 09, 2026 22:18:32
*** Written on Mon Mar 09, 2026 22:18:37 by Electric VLSI Design System, version 9.08
*** Layout tech: mocmos, foundry MOSIS
*** UC SPICE *** , MIN_RESIST 4.0, MIN_CAPAC 0.1FF

*** SUBCIRCUIT Lab4__NOT_GATE FROM CELL NOT_GATE{sch}
.SUBCKT Lab4__NOT_GATE in out
** GLOBAL gnd
** GLOBAL vdd
Mnmos@0 out in gnd gnd NMOS L=0.6U W=3U
Mpmos@0 out in vdd vdd PMOS L=0.6U W=6U
.ENDS Lab4__NOT_GATE

*** SUBCIRCUIT Lab4__NOT_GATE2 FROM CELL NOT_GATE2{sch}
.SUBCKT Lab4__NOT_GATE2 in out
** GLOBAL gnd
** GLOBAL vdd
Mnmos@0 out in gnd gnd NMOS L=1.8U W=7.2U
Mpmos@0 out in vdd vdd PMOS L=1.8U W=14.4U
.ENDS Lab4__NOT_GATE2

.global gnd vdd

*** TOP LEVEL CELL: INVERTERTEST2{sch}
Ccap@0 gnd vout2 {x}
Ccap@1 gnd vout1 {x}
XNOT_GATE@0 vin vout1 Lab4__NOT_GATE
XNOT_GATE@1 vin vout2 Lab4__NOT_GATE2

* Spice Code nodes in cell cell 'INVERTERTEST2{sch}'
vdd vdd 0 DC 5
vin vin 0 pulse(0v 5v 5n 1n 1n 12n 25n)
.step param x list 1f 10f 100f
.tran 0 25n 0 100p
.include C5_models.txt
.END
